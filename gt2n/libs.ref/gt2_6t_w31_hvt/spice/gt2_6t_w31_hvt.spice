* SPDX-License-Identifier: BSD-3-Clause
*
* GT2N standard-cell library gt2_6t_w31_hvt: SPICE netlist for ngspice / Xyce.
*
* Copyright 2025 Georgia Institute of Technology. See LICENSE in the GT2N
* repository root for the full BSD 3-Clause license text.
*
* THIS FILE IS GENERATED by gt2n/scripts/gen_spice.py from
* libs.ref/gt2_6t_w31_hvt/cdl/gt2_6t_w31_hvt.cdl -- do not edit by hand.
*
* Device models are not provided yet. The subcircuit wrappers nmos_hvt /
* pmos_hvt (terminals d g s b, parameters w l m) have to be written around
* the legacy BSIM-CMG cards device/tt/gt2_w31_hvt_tt.sp of the GT2N
* repository (.LIB nfet_typ / pfet_typ, models nmos / pmos).

.subckt gt2_6t_and2_x1_w31_hvt A B Y vdd vss
*.PININFO A:I B:I Y:O vdd:B vss:B
XMM7 Y net20 vdd vdd pmos_hvt w=0.031u l=0.014u m=1
XMM2 net20 B vdd vdd pmos_hvt w=0.031u l=0.014u m=1
XMM0 net20 A vdd vdd pmos_hvt w=0.031u l=0.014u m=1
XMM3 net13 B vss vss nmos_hvt w=0.031u l=0.014u m=1
XMM8 Y net20 vss vss nmos_hvt w=0.031u l=0.014u m=1
XMM1 net20 A net13 vss nmos_hvt w=0.031u l=0.014u m=1
.ends gt2_6t_and2_x1_w31_hvt

.subckt gt2_6t_and2_x2_w31_hvt A B Y vdd vss
*.PININFO A:I B:I Y:O vdd:B vss:B
XMM7 Y net20 vdd vdd pmos_hvt w=0.031u l=0.014u m=2
XMM2 net20 B vdd vdd pmos_hvt w=0.031u l=0.014u m=1
XMM0 net20 A vdd vdd pmos_hvt w=0.031u l=0.014u m=1
XMM3 net13 B vss vss nmos_hvt w=0.031u l=0.014u m=1
XMM8 Y net20 vss vss nmos_hvt w=0.031u l=0.014u m=2
XMM1 net20 A net13 vss nmos_hvt w=0.031u l=0.014u m=1
.ends gt2_6t_and2_x2_w31_hvt

.subckt gt2_6t_and2_x3_w31_hvt A B Y vdd vss
*.PININFO A:I B:I Y:O vdd:B vss:B
XMM7 Y net20 vdd vdd pmos_hvt w=0.031u l=0.014u m=3
XMM2 net20 B vdd vdd pmos_hvt w=0.031u l=0.014u m=1
XMM0 net20 A vdd vdd pmos_hvt w=0.031u l=0.014u m=1
XMM8 Y net20 vss vss nmos_hvt w=0.031u l=0.014u m=3
XMM3 net13 B vss vss nmos_hvt w=0.031u l=0.014u m=1
XMM1 net20 A net13 vss nmos_hvt w=0.031u l=0.014u m=1
.ends gt2_6t_and2_x3_w31_hvt

.subckt gt2_6t_and2_x4_w31_hvt A B Y vdd vss
*.PININFO A:I B:I Y:O vdd:B vss:B
XMM7 Y net20 vdd vdd pmos_hvt w=0.031u l=0.014u m=4
XMM2 net20 B vdd vdd pmos_hvt w=0.031u l=0.014u m=1
XMM0 net20 A vdd vdd pmos_hvt w=0.031u l=0.014u m=1
XMM8 Y net20 vss vss nmos_hvt w=0.031u l=0.014u m=4
XMM3 net13 B vss vss nmos_hvt w=0.031u l=0.014u m=1
XMM1 net20 A net13 vss nmos_hvt w=0.031u l=0.014u m=1
.ends gt2_6t_and2_x4_w31_hvt

.subckt gt2_6t_and3_x1_w31_hvt A B C Y vdd vss
*.PININFO A:I B:I C:I Y:O vdd:B vss:B
XMM11 net20 C vdd vdd pmos_hvt w=0.031u l=0.014u m=1
XMM7 Y net20 vdd vdd pmos_hvt w=0.031u l=0.014u m=1
XMM2 net20 B vdd vdd pmos_hvt w=0.031u l=0.014u m=1
XMM0 net20 A vdd vdd pmos_hvt w=0.031u l=0.014u m=1
XMM9 net23 C vss vss nmos_hvt w=0.031u l=0.014u m=1
XMM8 Y net20 vss vss nmos_hvt w=0.031u l=0.014u m=1
XMM3 net13 B net23 vss nmos_hvt w=0.031u l=0.014u m=1
XMM1 net20 A net13 vss nmos_hvt w=0.031u l=0.014u m=1
.ends gt2_6t_and3_x1_w31_hvt

.subckt gt2_6t_ao211_x1_w31_hvt A1 A2 B C Y vdd vss
*.PININFO A1:I A2:I B:I C:I Y:O vdd:B vss:B
XMM18 net41 A2 vss vss nmos_hvt w=0.031u l=0.014u m=1
XMM27 Y net87 vss vss nmos_hvt w=0.031u l=0.014u m=1
XMM19 net87 C vss vss nmos_hvt w=0.031u l=0.014u m=1
XMM28 net87 B vss vss nmos_hvt w=0.031u l=0.014u m=1
XMM17 net87 A1 net41 vss nmos_hvt w=0.031u l=0.014u m=1
XMM26 Y net87 vdd vdd pmos_hvt w=0.031u l=0.014u m=1
XMM15 net87 C net86 vdd pmos_hvt w=0.031u l=0.014u m=1
XMM14 net86 B net64 vdd pmos_hvt w=0.031u l=0.014u m=1
XMM29 net64 A1 vdd vdd pmos_hvt w=0.031u l=0.014u m=1
XMM16 net64 A2 vdd vdd pmos_hvt w=0.031u l=0.014u m=1
.ends gt2_6t_ao211_x1_w31_hvt

.subckt gt2_6t_ao21_x1_w31_hvt A1 A2 B Y vdd vss
*.PININFO A1:I A2:I B:I Y:O vdd:B vss:B
XMM19 net67 B vss vss nmos_hvt w=0.031u l=0.014u m=1
XMM18 net41 A2 vss vss nmos_hvt w=0.031u l=0.014u m=1
XMM17 net67 A1 net41 vss nmos_hvt w=0.031u l=0.014u m=1
XMM27 Y net67 vss vss nmos_hvt w=0.031u l=0.014u m=1
XMM16 net64 B vdd vdd pmos_hvt w=0.031u l=0.014u m=1
XMM26 Y net67 vdd vdd pmos_hvt w=0.031u l=0.014u m=1
XMM14 net67 A1 net64 vdd pmos_hvt w=0.031u l=0.014u m=1
XMM15 net67 A2 net64 vdd pmos_hvt w=0.031u l=0.014u m=1
.ends gt2_6t_ao21_x1_w31_hvt

.subckt gt2_6t_ao22_x1_w31_hvt A1 A2 B1 B2 Y vdd vss
*.PININFO A1:I A2:I B1:I B2:I Y:O vdd:B vss:B
XMM28 net69 B1 vss vss nmos_hvt w=0.031u l=0.014u m=1
XMM18 net41 A1 vss vss nmos_hvt w=0.031u l=0.014u m=1
XMM27 Y net67 vss vss nmos_hvt w=0.031u l=0.014u m=1
XMM19 net67 B2 net69 vss nmos_hvt w=0.031u l=0.014u m=1
XMM17 net67 A2 net41 vss nmos_hvt w=0.031u l=0.014u m=1
XMM26 Y net67 vdd vdd pmos_hvt w=0.031u l=0.014u m=1
XMM15 net67 B2 net64 vdd pmos_hvt w=0.031u l=0.014u m=1
XMM14 net67 B1 net64 vdd pmos_hvt w=0.031u l=0.014u m=1
XMM29 net64 A2 vdd vdd pmos_hvt w=0.031u l=0.014u m=1
XMM16 net64 A1 vdd vdd pmos_hvt w=0.031u l=0.014u m=1
.ends gt2_6t_ao22_x1_w31_hvt

.subckt gt2_6t_ao31_x1_w31_hvt A1 A2 A3 B Y vdd vss
*.PININFO A1:I A2:I A3:I B:I Y:O vdd:B vss:B
XMM27 Y net91 vss vss nmos_hvt w=0.031u l=0.014u m=1
XMM18 net98 A3 vss vss nmos_hvt w=0.031u l=0.014u m=1
XMM32 net97 A2 net98 vss nmos_hvt w=0.031u l=0.014u m=1
XMM19 net91 B vss vss nmos_hvt w=0.031u l=0.014u m=1
XMM17 net91 A1 net97 vss nmos_hvt w=0.031u l=0.014u m=1
XMM26 Y net91 vdd vdd pmos_hvt w=0.031u l=0.014u m=1
XMM14 net91 B net92 vdd pmos_hvt w=0.031u l=0.014u m=1
XMM31 net92 A3 vdd vdd pmos_hvt w=0.031u l=0.014u m=1
XMM29 net92 A2 vdd vdd pmos_hvt w=0.031u l=0.014u m=1
XMM16 net92 A1 vdd vdd pmos_hvt w=0.031u l=0.014u m=1
.ends gt2_6t_ao31_x1_w31_hvt

.subckt gt2_6t_ao32_x1_w31_hvt A1 A2 A3 B1 B2 Y vdd vss
*.PININFO A1:I A2:I A3:I B1:I B2:I Y:O vdd:B vss:B
XMM18 net98 A3 vss vss nmos_hvt w=0.031u l=0.014u m=1
XMM35 net106 B2 vss vss nmos_hvt w=0.031u l=0.014u m=1
XMM32 net97 A2 net98 vss nmos_hvt w=0.031u l=0.014u m=1
XMM19 net91 B1 net106 vss nmos_hvt w=0.031u l=0.014u m=1
XMM27 Y net91 vss vss nmos_hvt w=0.031u l=0.014u m=1
XMM17 net91 A1 net97 vss nmos_hvt w=0.031u l=0.014u m=1
XMM26 Y net91 vdd vdd pmos_hvt w=0.031u l=0.014u m=1
XMM34 net91 B2 net92 vdd pmos_hvt w=0.031u l=0.014u m=1
XMM14 net91 B1 net92 vdd pmos_hvt w=0.031u l=0.014u m=1
XMM31 net92 A3 vdd vdd pmos_hvt w=0.031u l=0.014u m=1
XMM29 net92 A2 vdd vdd pmos_hvt w=0.031u l=0.014u m=1
XMM16 net92 A1 vdd vdd pmos_hvt w=0.031u l=0.014u m=1
.ends gt2_6t_ao32_x1_w31_hvt

.subckt gt2_6t_ao33_x1_w31_hvt A1 A2 A3 B1 B2 B3 Y vdd vss
*.PININFO A1:I A2:I A3:I B1:I B2:I B3:I Y:O vdd:B vss:B
XMM27 Y net91 vss vss nmos_hvt w=0.031u l=0.014u m=1
XMM36 net110 B3 vss vss nmos_hvt w=0.031u l=0.014u m=1
XMM18 net98 A3 vss vss nmos_hvt w=0.031u l=0.014u m=1
XMM35 net106 B2 net110 vss nmos_hvt w=0.031u l=0.014u m=1
XMM32 net97 A2 net98 vss nmos_hvt w=0.031u l=0.014u m=1
XMM19 net91 B1 net106 vss nmos_hvt w=0.031u l=0.014u m=1
XMM17 net91 A1 net97 vss nmos_hvt w=0.031u l=0.014u m=1
XMM26 Y net91 vdd vdd pmos_hvt w=0.031u l=0.014u m=1
XMM37 net91 B3 net92 vdd pmos_hvt w=0.031u l=0.014u m=1
XMM34 net91 B2 net92 vdd pmos_hvt w=0.031u l=0.014u m=1
XMM14 net91 B1 net92 vdd pmos_hvt w=0.031u l=0.014u m=1
XMM31 net92 A3 vdd vdd pmos_hvt w=0.031u l=0.014u m=1
XMM29 net92 A2 vdd vdd pmos_hvt w=0.031u l=0.014u m=1
XMM16 net92 A1 vdd vdd pmos_hvt w=0.031u l=0.014u m=1
.ends gt2_6t_ao33_x1_w31_hvt

.subckt gt2_6t_aoi211_x1_w31_hvt A1 A2 B C Y vdd vss
*.PININFO A1:I A2:I B:I C:I Y:O vdd:B vss:B
XMM15 Y C net86 vdd pmos_hvt w=0.031u l=0.014u m=1
XMM14 net86 B net64 vdd pmos_hvt w=0.031u l=0.014u m=1
XMM29 net64 A1 vdd vdd pmos_hvt w=0.031u l=0.014u m=1
XMM16 net64 A2 vdd vdd pmos_hvt w=0.031u l=0.014u m=1
XMM18 net41 A2 vss vss nmos_hvt w=0.031u l=0.014u m=1
XMM19 Y C vss vss nmos_hvt w=0.031u l=0.014u m=1
XMM28 Y B vss vss nmos_hvt w=0.031u l=0.014u m=1
XMM17 Y A1 net41 vss nmos_hvt w=0.031u l=0.014u m=1
.ends gt2_6t_aoi211_x1_w31_hvt

.subckt gt2_6t_aoi21_x1_w31_hvt A1 A2 B Y vdd vss
*.PININFO A1:I A2:I B:I Y:O vdd:B vss:B
XMM28 net78 A2 vss vss nmos_hvt w=0.031u l=0.014u m=1
XMM29 Y B vss vss nmos_hvt w=0.031u l=0.014u m=1
XMM30 Y A1 net78 vss nmos_hvt w=0.031u l=0.014u m=1
XMM31 net83 B vdd vdd pmos_hvt w=0.031u l=0.014u m=1
XMM32 Y A2 net83 vdd pmos_hvt w=0.031u l=0.014u m=1
XMM33 Y A1 net83 vdd pmos_hvt w=0.031u l=0.014u m=1
.ends gt2_6t_aoi21_x1_w31_hvt

.subckt gt2_6t_aoi22_x1_w31_hvt A1 A2 B1 B2 Y vdd vss
*.PININFO A1:I A2:I B1:I B2:I Y:O vdd:B vss:B
XMM15 Y B2 net64 vdd pmos_hvt w=0.031u l=0.014u m=1
XMM14 Y B1 net64 vdd pmos_hvt w=0.031u l=0.014u m=1
XMM29 net64 A2 vdd vdd pmos_hvt w=0.031u l=0.014u m=1
XMM16 net64 A1 vdd vdd pmos_hvt w=0.031u l=0.014u m=1
XMM28 net69 B1 vss vss nmos_hvt w=0.031u l=0.014u m=1
XMM18 net41 A1 vss vss nmos_hvt w=0.031u l=0.014u m=1
XMM19 Y B2 net69 vss nmos_hvt w=0.031u l=0.014u m=1
XMM17 Y A2 net41 vss nmos_hvt w=0.031u l=0.014u m=1
.ends gt2_6t_aoi22_x1_w31_hvt

.subckt gt2_6t_aoi31_x1_w31_hvt A1 A2 A3 B Y vdd vss
*.PININFO A1:I A2:I A3:I B:I Y:O vdd:B vss:B
XMM18 net98 A3 vss vss nmos_hvt w=0.031u l=0.014u m=1
XMM32 net97 A2 net98 vss nmos_hvt w=0.031u l=0.014u m=1
XMM19 Y B vss vss nmos_hvt w=0.031u l=0.014u m=1
XMM17 Y A1 net97 vss nmos_hvt w=0.031u l=0.014u m=1
XMM14 Y B net92 vdd pmos_hvt w=0.031u l=0.014u m=1
XMM31 net92 A3 vdd vdd pmos_hvt w=0.031u l=0.014u m=1
XMM29 net92 A2 vdd vdd pmos_hvt w=0.031u l=0.014u m=1
XMM16 net92 A1 vdd vdd pmos_hvt w=0.031u l=0.014u m=1
.ends gt2_6t_aoi31_x1_w31_hvt

.subckt gt2_6t_aoi32_x1_w31_hvt A1 A2 A3 B1 B2 Y vdd vss
*.PININFO A1:I A2:I A3:I B1:I B2:I Y:O vdd:B vss:B
XMM34 Y B2 net92 vdd pmos_hvt w=0.031u l=0.014u m=1
XMM14 Y B1 net92 vdd pmos_hvt w=0.031u l=0.014u m=1
XMM31 net92 A3 vdd vdd pmos_hvt w=0.031u l=0.014u m=1
XMM29 net92 A2 vdd vdd pmos_hvt w=0.031u l=0.014u m=1
XMM16 net92 A1 vdd vdd pmos_hvt w=0.031u l=0.014u m=1
XMM18 net98 A3 vss vss nmos_hvt w=0.031u l=0.014u m=1
XMM35 net106 B2 vss vss nmos_hvt w=0.031u l=0.014u m=1
XMM32 net97 A2 net98 vss nmos_hvt w=0.031u l=0.014u m=1
XMM19 Y B1 net106 vss nmos_hvt w=0.031u l=0.014u m=1
XMM17 Y A1 net97 vss nmos_hvt w=0.031u l=0.014u m=1
.ends gt2_6t_aoi32_x1_w31_hvt

.subckt gt2_6t_aoi33_x1_w31_hvt A1 A2 A3 B1 B2 B3 Y vdd vss
*.PININFO A1:I A2:I A3:I B1:I B2:I B3:I Y:O vdd:B vss:B
XMM37 Y B3 net92 vdd pmos_hvt w=0.031u l=0.014u m=1
XMM34 Y B2 net92 vdd pmos_hvt w=0.031u l=0.014u m=1
XMM14 Y B1 net92 vdd pmos_hvt w=0.031u l=0.014u m=1
XMM31 net92 A3 vdd vdd pmos_hvt w=0.031u l=0.014u m=1
XMM29 net92 A2 vdd vdd pmos_hvt w=0.031u l=0.014u m=1
XMM16 net92 A1 vdd vdd pmos_hvt w=0.031u l=0.014u m=1
XMM36 net110 B3 vss vss nmos_hvt w=0.031u l=0.014u m=1
XMM18 net98 A3 vss vss nmos_hvt w=0.031u l=0.014u m=1
XMM35 net106 B2 net110 vss nmos_hvt w=0.031u l=0.014u m=1
XMM32 net97 A2 net98 vss nmos_hvt w=0.031u l=0.014u m=1
XMM19 Y B1 net106 vss nmos_hvt w=0.031u l=0.014u m=1
XMM17 Y A1 net97 vss nmos_hvt w=0.031u l=0.014u m=1
.ends gt2_6t_aoi33_x1_w31_hvt

.subckt gt2_6t_buf_x1_w31_hvt A Y vdd vss
*.PININFO A:I Y:O vdd:B vss:B
XMM2 Y net13 vdd vdd pmos_hvt w=0.031u l=0.014u m=1
XMM0 net13 A vdd vdd pmos_hvt w=0.031u l=0.014u m=1
XMM1 net13 A vss vss nmos_hvt w=0.031u l=0.014u m=1
XMM3 Y net13 vss vss nmos_hvt w=0.031u l=0.014u m=1
.ends gt2_6t_buf_x1_w31_hvt

.subckt gt2_6t_buf_x2_w31_hvt A Y vdd vss
*.PININFO A:I Y:O vdd:B vss:B
XMM2 Y net13 vdd vdd pmos_hvt w=0.031u l=0.014u m=2
XMM0 net13 A vdd vdd pmos_hvt w=0.031u l=0.014u m=1
XMM3 Y net13 vss vss nmos_hvt w=0.031u l=0.014u m=2
XMM1 net13 A vss vss nmos_hvt w=0.031u l=0.014u m=1
.ends gt2_6t_buf_x2_w31_hvt

.subckt gt2_6t_buf_x3_w31_hvt A Y vdd vss
*.PININFO A:I Y:O vdd:B vss:B
XMM2 Y net13 vdd vdd pmos_hvt w=0.031u l=0.014u m=3
XMM0 net13 A vdd vdd pmos_hvt w=0.031u l=0.014u m=1
XMM3 Y net13 vss vss nmos_hvt w=0.031u l=0.014u m=3
XMM1 net13 A vss vss nmos_hvt w=0.031u l=0.014u m=1
.ends gt2_6t_buf_x3_w31_hvt

.subckt gt2_6t_buf_x4_w31_hvt A Y vdd vss
*.PININFO A:I Y:O vdd:B vss:B
XMM2 Y net13 vdd vdd pmos_hvt w=0.031u l=0.014u m=4
XMM0 net13 A vdd vdd pmos_hvt w=0.031u l=0.014u m=1
XMM3 Y net13 vss vss nmos_hvt w=0.031u l=0.014u m=4
XMM1 net13 A vss vss nmos_hvt w=0.031u l=0.014u m=1
.ends gt2_6t_buf_x4_w31_hvt

.subckt gt2_6t_buf_x6_w31_hvt A Y vdd vss
*.PININFO A:I Y:O vdd:B vss:B
XMM2 Y net13 vdd vdd pmos_hvt w=0.031u l=0.014u m=6
XMM0 net13 A vdd vdd pmos_hvt w=0.031u l=0.014u m=2
XMM3 Y net13 vss vss nmos_hvt w=0.031u l=0.014u m=6
XMM1 net13 A vss vss nmos_hvt w=0.031u l=0.014u m=2
.ends gt2_6t_buf_x6_w31_hvt

.subckt gt2_6t_buf_x8_w31_hvt A Y vdd vss
*.PININFO A:I Y:O vdd:B vss:B
XMM2 Y net13 vdd vdd pmos_hvt w=0.031u l=0.014u m=8
XMM0 net13 A vdd vdd pmos_hvt w=0.031u l=0.014u m=2
XMM3 Y net13 vss vss nmos_hvt w=0.031u l=0.014u m=8
XMM1 net13 A vss vss nmos_hvt w=0.031u l=0.014u m=2
.ends gt2_6t_buf_x8_w31_hvt

.subckt gt2_6t_buf_x10_w31_hvt A Y vdd vss
*.PININFO A:I Y:O vdd:B vss:B
XMM2 Y net13 vdd vdd pmos_hvt w=0.031u l=0.014u m=10
XMM0 net13 A vdd vdd pmos_hvt w=0.031u l=0.014u m=3
XMM3 Y net13 vss vss nmos_hvt w=0.031u l=0.014u m=10
XMM1 net13 A vss vss nmos_hvt w=0.031u l=0.014u m=3
.ends gt2_6t_buf_x10_w31_hvt

.subckt gt2_6t_buf_x12_w31_hvt A Y vdd vss
*.PININFO A:I Y:O vdd:B vss:B
XMM2 Y net13 vdd vdd pmos_hvt w=0.031u l=0.014u m=12
XMM0 net13 A vdd vdd pmos_hvt w=0.031u l=0.014u m=3
XMM3 Y net13 vss vss nmos_hvt w=0.031u l=0.014u m=12
XMM1 net13 A vss vss nmos_hvt w=0.031u l=0.014u m=3
.ends gt2_6t_buf_x12_w31_hvt

.subckt gt2_6t_decapcc_w31_hvt vdd vss
*.PININFO vdd:B vss:B
XMM1 net7 net12 vss vss nmos_hvt w=0.031u l=0.014u m=1
XMM0 net12 net7 vdd vdd pmos_hvt w=0.031u l=0.014u m=1
.ends gt2_6t_decapcc_w31_hvt

.subckt gt2_6t_nand3_x1_w31_hvt A B C Y vdd vss
*.PININFO A:I B:I C:I Y:O vdd:B vss:B
XMM9 Y A vdd vdd pmos_hvt w=0.031u l=0.014u m=1
XMM2 Y B vdd vdd pmos_hvt w=0.031u l=0.014u m=1
XMM0 Y C vdd vdd pmos_hvt w=0.031u l=0.014u m=1
XMM7 net15 A vss vss nmos_hvt w=0.031u l=0.014u m=1
XMM3 net13 B net15 vss nmos_hvt w=0.031u l=0.014u m=1
XMM1 Y C net13 vss nmos_hvt w=0.031u l=0.014u m=1
.ends gt2_6t_nand3_x1_w31_hvt

.subckt gt2_6t_dffasync_x1_w31_hvt CLK D Q RESETN SETN vdd vss
*.PININFO CLK:I D:I Q:O RESETN:I SETN:I vdd:B vss:B
XI5 net13 Q RESETN net21 vdd vss gt2_6t_nand3_x1_w31_hvt
XI4 net5 SETN net21 Q vdd vss gt2_6t_nand3_x1_w31_hvt
XI3 CLK net9 net5 net13 vdd vss gt2_6t_nand3_x1_w31_hvt
XI2 net13 D RESETN net9 vdd vss gt2_6t_nand3_x1_w31_hvt
XI1 RESETN net7 CLK net5 vdd vss gt2_6t_nand3_x1_w31_hvt
XI0 SETN net9 net5 net7 vdd vss gt2_6t_nand3_x1_w31_hvt
.ends gt2_6t_dffasync_x1_w31_hvt

.subckt gt2_6t_dffasync_x2_w31_hvt CLK D Q RESETN SETN vdd vss
*.PININFO CLK:I D:I Q:O RESETN:I SETN:I vdd:B vss:B
XMM20 Q net53 vdd vdd pmos_hvt w=0.031u l=0.014u m=1
XMM18 net53 net54 vdd vdd pmos_hvt w=0.031u l=0.014u m=1
XMM16 Q net49 vdd vdd pmos_hvt w=0.031u l=0.014u m=1
XMM14 net49 net54 vdd vdd pmos_hvt w=0.031u l=0.014u m=1
XI5 net13 net54 RESETN net21 vdd vss gt2_6t_nand3_x1_w31_hvt
XI4 net5 SETN net21 net54 vdd vss gt2_6t_nand3_x1_w31_hvt
XI3 CLK net9 net5 net13 vdd vss gt2_6t_nand3_x1_w31_hvt
XI2 net13 D RESETN net9 vdd vss gt2_6t_nand3_x1_w31_hvt
XI1 RESETN net7 CLK net5 vdd vss gt2_6t_nand3_x1_w31_hvt
XI0 SETN net9 net5 net7 vdd vss gt2_6t_nand3_x1_w31_hvt
XMM21 Q net53 vss vss nmos_hvt w=0.031u l=0.014u m=1
XMM19 net53 net54 vss vss nmos_hvt w=0.031u l=0.014u m=1
XMM17 Q net49 vss vss nmos_hvt w=0.031u l=0.014u m=1
XMM15 net49 net54 vss vss nmos_hvt w=0.031u l=0.014u m=1
.ends gt2_6t_dffasync_x2_w31_hvt

.subckt gt2_6t_dffasync_x4_w31_hvt CLK D Q RESETN SETN vdd vss
*.PININFO CLK:I D:I Q:O RESETN:I SETN:I vdd:B vss:B
XMM20 Q net53 vdd vdd pmos_hvt w=0.031u l=0.014u m=2
XMM18 net53 net54 vdd vdd pmos_hvt w=0.031u l=0.014u m=1
XMM16 Q net49 vdd vdd pmos_hvt w=0.031u l=0.014u m=2
XMM14 net49 net54 vdd vdd pmos_hvt w=0.031u l=0.014u m=1
XI5 net13 net54 RESETN net21 vdd vss gt2_6t_nand3_x1_w31_hvt
XI4 net5 SETN net21 net54 vdd vss gt2_6t_nand3_x1_w31_hvt
XI3 CLK net9 net5 net13 vdd vss gt2_6t_nand3_x1_w31_hvt
XI2 net13 D RESETN net9 vdd vss gt2_6t_nand3_x1_w31_hvt
XI1 RESETN net7 CLK net5 vdd vss gt2_6t_nand3_x1_w31_hvt
XI0 SETN net9 net5 net7 vdd vss gt2_6t_nand3_x1_w31_hvt
XMM21 Q net53 vss vss nmos_hvt w=0.031u l=0.014u m=2
XMM19 net53 net54 vss vss nmos_hvt w=0.031u l=0.014u m=1
XMM17 Q net49 vss vss nmos_hvt w=0.031u l=0.014u m=2
XMM15 net49 net54 vss vss nmos_hvt w=0.031u l=0.014u m=1
.ends gt2_6t_dffasync_x4_w31_hvt

.subckt gt2_6t_inv_x1_w31_hvt A Y vdd vss
*.PININFO A:I Y:O vdd:B vss:B
XMM0 Y A vdd vdd pmos_hvt w=0.031u l=0.014u m=1
XMM1 Y A vss vss nmos_hvt w=0.031u l=0.014u m=1
.ends gt2_6t_inv_x1_w31_hvt

.subckt gt2_6t_inv_x2_w31_hvt A Y vdd vss
*.PININFO A:I Y:O vdd:B vss:B
XMM0 Y A vdd vdd pmos_hvt w=0.031u l=0.014u m=2
XMM1 Y A vss vss nmos_hvt w=0.031u l=0.014u m=2
.ends gt2_6t_inv_x2_w31_hvt

.subckt gt2_6t_inv_x3_w31_hvt A Y vdd vss
*.PININFO A:I Y:O vdd:B vss:B
XMM0 Y A vdd vdd pmos_hvt w=0.031u l=0.014u m=3
XMM1 Y A vss vss nmos_hvt w=0.031u l=0.014u m=3
.ends gt2_6t_inv_x3_w31_hvt

.subckt gt2_6t_inv_x4_w31_hvt A Y vdd vss
*.PININFO A:I Y:O vdd:B vss:B
XMM0 Y A vdd vdd pmos_hvt w=0.031u l=0.014u m=4
XMM1 Y A vss vss nmos_hvt w=0.031u l=0.014u m=4
.ends gt2_6t_inv_x4_w31_hvt

.subckt gt2_6t_inv_x6_w31_hvt A Y vdd vss
*.PININFO A:I Y:O vdd:B vss:B
XMM0 Y A vdd vdd pmos_hvt w=0.031u l=0.014u m=6
XMM1 Y A vss vss nmos_hvt w=0.031u l=0.014u m=6
.ends gt2_6t_inv_x6_w31_hvt

.subckt gt2_6t_inv_x8_w31_hvt A Y vdd vss
*.PININFO A:I Y:O vdd:B vss:B
XMM0 Y A vdd vdd pmos_hvt w=0.031u l=0.014u m=8
XMM1 Y A vss vss nmos_hvt w=0.031u l=0.014u m=8
.ends gt2_6t_inv_x8_w31_hvt

.subckt gt2_6t_inv_x10_w31_hvt A Y vdd vss
*.PININFO A:I Y:O vdd:B vss:B
XMM0 Y A vdd vdd pmos_hvt w=0.031u l=0.014u m=10
XMM1 Y A vss vss nmos_hvt w=0.031u l=0.014u m=10
.ends gt2_6t_inv_x10_w31_hvt

.subckt gt2_6t_inv_x12_w31_hvt A Y vdd vss
*.PININFO A:I Y:O vdd:B vss:B
XMM0 Y A vdd vdd pmos_hvt w=0.031u l=0.014u m=12
XMM1 Y A vss vss nmos_hvt w=0.031u l=0.014u m=12
.ends gt2_6t_inv_x12_w31_hvt

.subckt gt2_6t_mux2_x1_w31_hvt A B S Y vdd vss
*.PININFO A:I B:I S:I Y:O vdd:B vss:B
XMM15 net30 S vdd vdd pmos_hvt w=0.031u l=0.014u m=1
XMM13 Y net36 vdd vdd pmos_hvt w=0.031u l=0.014u m=1
XMM11 Y net37 vdd vdd pmos_hvt w=0.031u l=0.014u m=1
XMM9 net36 B vdd vdd pmos_hvt w=0.031u l=0.014u m=1
XMM7 net36 S vdd vdd pmos_hvt w=0.031u l=0.014u m=1
XMM2 net37 A vdd vdd pmos_hvt w=0.031u l=0.014u m=1
XMM0 net37 net30 vdd vdd pmos_hvt w=0.031u l=0.014u m=1
XMM16 net30 S vss vss nmos_hvt w=0.031u l=0.014u m=1
XMM14 net26 net36 vss vss nmos_hvt w=0.031u l=0.014u m=1
XMM12 Y net37 net26 vss nmos_hvt w=0.031u l=0.014u m=1
XMM10 net20 B vss vss nmos_hvt w=0.031u l=0.014u m=1
XMM8 net36 S net20 vss nmos_hvt w=0.031u l=0.014u m=1
XMM3 net13 A vss vss nmos_hvt w=0.031u l=0.014u m=1
XMM1 net37 net30 net13 vss nmos_hvt w=0.031u l=0.014u m=1
.ends gt2_6t_mux2_x1_w31_hvt

.subckt gt2_6t_nand2_x1_w31_hvt A B Y vdd vss
*.PININFO A:I B:I Y:O vdd:B vss:B
XMM3 net13 A vss vss nmos_hvt w=0.031u l=0.014u m=1
XMM1 Y B net13 vss nmos_hvt w=0.031u l=0.014u m=1
XMM0 Y B vdd vdd pmos_hvt w=0.031u l=0.014u m=1
XMM2 Y A vdd vdd pmos_hvt w=0.031u l=0.014u m=1
.ends gt2_6t_nand2_x1_w31_hvt

.subckt gt2_6t_nand2_x2_w31_hvt A B Y vdd vss
*.PININFO A:I B:I Y:O vdd:B vss:B
XMM8 net17 A vss vss nmos_hvt w=0.031u l=0.014u m=1
XMM3 net13 A vss vss nmos_hvt w=0.031u l=0.014u m=1
XMM7 Y B net17 vss nmos_hvt w=0.031u l=0.014u m=1
XMM1 Y B net13 vss nmos_hvt w=0.031u l=0.014u m=1
XMM2 Y A vdd vdd pmos_hvt w=0.031u l=0.014u m=2
XMM0 Y B vdd vdd pmos_hvt w=0.031u l=0.014u m=2
.ends gt2_6t_nand2_x2_w31_hvt

.subckt gt2_6t_nand2_x3_w31_hvt A B Y vdd vss
*.PININFO A:I B:I Y:O vdd:B vss:B
XMM10 net23 A vss vss nmos_hvt w=0.031u l=0.014u m=1
XMM9 Y B net23 vss nmos_hvt w=0.031u l=0.014u m=1
XMM8 net17 A vss vss nmos_hvt w=0.031u l=0.014u m=1
XMM7 Y B net17 vss nmos_hvt w=0.031u l=0.014u m=1
XMM3 net13 A vss vss nmos_hvt w=0.031u l=0.014u m=1
XMM1 Y B net13 vss nmos_hvt w=0.031u l=0.014u m=1
XMM2 Y A vdd vdd pmos_hvt w=0.031u l=0.014u m=3
XMM0 Y B vdd vdd pmos_hvt w=0.031u l=0.014u m=3
.ends gt2_6t_nand2_x3_w31_hvt

.subckt gt2_6t_nand2_x4_w31_hvt A B Y vdd vss
*.PININFO A:I B:I Y:O vdd:B vss:B
XMM12 net29 A vss vss nmos_hvt w=0.031u l=0.014u m=1
XMM11 Y B net29 vss nmos_hvt w=0.031u l=0.014u m=1
XMM10 net23 A vss vss nmos_hvt w=0.031u l=0.014u m=1
XMM9 Y B net23 vss nmos_hvt w=0.031u l=0.014u m=1
XMM7 Y B net17 vss nmos_hvt w=0.031u l=0.014u m=1
XMM8 net17 A vss vss nmos_hvt w=0.031u l=0.014u m=1
XMM3 net13 A vss vss nmos_hvt w=0.031u l=0.014u m=1
XMM1 Y B net13 vss nmos_hvt w=0.031u l=0.014u m=1
XMM2 Y A vdd vdd pmos_hvt w=0.031u l=0.014u m=4
XMM0 Y B vdd vdd pmos_hvt w=0.031u l=0.014u m=4
.ends gt2_6t_nand2_x4_w31_hvt

.subckt gt2_6t_nor2_x1_w31_hvt A B Y vdd vss
*.PININFO A:I B:I Y:O vdd:B vss:B
XMM1 Y A vss vss nmos_hvt w=0.031u l=0.014u m=1
XMM3 Y B vss vss nmos_hvt w=0.031u l=0.014u m=1
XMM2 Y B net22 vdd pmos_hvt w=0.031u l=0.014u m=1
XMM0 net22 A vdd vdd pmos_hvt w=0.031u l=0.014u m=1
.ends gt2_6t_nor2_x1_w31_hvt

.subckt gt2_6t_nor2_x2_w31_hvt A B Y vdd vss
*.PININFO A:I B:I Y:O vdd:B vss:B
XMM3 Y B vss vss nmos_hvt w=0.031u l=0.014u m=2
XMM1 Y A vss vss nmos_hvt w=0.031u l=0.014u m=2
XMM8 Y B net26 vdd pmos_hvt w=0.031u l=0.014u m=1
XMM2 Y B net22 vdd pmos_hvt w=0.031u l=0.014u m=1
XMM7 net26 A vdd vdd pmos_hvt w=0.031u l=0.014u m=1
XMM0 net22 A vdd vdd pmos_hvt w=0.031u l=0.014u m=1
.ends gt2_6t_nor2_x2_w31_hvt

.subckt gt2_6t_nor2_x3_w31_hvt A B Y vdd vss
*.PININFO A:I B:I Y:O vdd:B vss:B
XMM3 Y B vss vss nmos_hvt w=0.031u l=0.014u m=3
XMM1 Y A vss vss nmos_hvt w=0.031u l=0.014u m=3
XMM10 Y B net32 vdd pmos_hvt w=0.031u l=0.014u m=1
XMM8 Y B net26 vdd pmos_hvt w=0.031u l=0.014u m=1
XMM2 Y B net22 vdd pmos_hvt w=0.031u l=0.014u m=1
XMM9 net32 A vdd vdd pmos_hvt w=0.031u l=0.014u m=1
XMM7 net26 A vdd vdd pmos_hvt w=0.031u l=0.014u m=1
XMM0 net22 A vdd vdd pmos_hvt w=0.031u l=0.014u m=1
.ends gt2_6t_nor2_x3_w31_hvt

.subckt gt2_6t_nor2_x4_w31_hvt A B Y vdd vss
*.PININFO A:I B:I Y:O vdd:B vss:B
XMM3 Y B vss vss nmos_hvt w=0.031u l=0.014u m=4
XMM1 Y A vss vss nmos_hvt w=0.031u l=0.014u m=4
XMM12 Y B net38 vdd pmos_hvt w=0.031u l=0.014u m=1
XMM10 Y B net32 vdd pmos_hvt w=0.031u l=0.014u m=1
XMM8 Y B net26 vdd pmos_hvt w=0.031u l=0.014u m=1
XMM2 Y B net22 vdd pmos_hvt w=0.031u l=0.014u m=1
XMM11 net38 A vdd vdd pmos_hvt w=0.031u l=0.014u m=1
XMM9 net32 A vdd vdd pmos_hvt w=0.031u l=0.014u m=1
XMM7 net26 A vdd vdd pmos_hvt w=0.031u l=0.014u m=1
XMM0 net22 A vdd vdd pmos_hvt w=0.031u l=0.014u m=1
.ends gt2_6t_nor2_x4_w31_hvt

.subckt gt2_6t_nor3_x1_w31_hvt A B C Y vdd vss
*.PININFO A:I B:I C:I Y:O vdd:B vss:B
XMM9 Y C vss vss nmos_hvt w=0.031u l=0.014u m=1
XMM3 Y B vss vss nmos_hvt w=0.031u l=0.014u m=1
XMM1 Y A vss vss nmos_hvt w=0.031u l=0.014u m=1
XMM7 Y C net24 vdd pmos_hvt w=0.031u l=0.014u m=1
XMM2 net24 B net22 vdd pmos_hvt w=0.031u l=0.014u m=1
XMM0 net22 A vdd vdd pmos_hvt w=0.031u l=0.014u m=1
.ends gt2_6t_nor3_x1_w31_hvt

.subckt gt2_6t_oa211_x1_w31_hvt A1 A2 B C Y vdd vss
*.PININFO A1:I A2:I B:I C:I Y:O vdd:B vss:B
XMM27 net110 A2 net69 vdd pmos_hvt w=0.031u l=0.014u m=1
XMM33 Y net110 vdd vdd pmos_hvt w=0.031u l=0.014u m=1
XMM35 net110 C vdd vdd pmos_hvt w=0.031u l=0.014u m=1
XMM28 net110 B vdd vdd pmos_hvt w=0.031u l=0.014u m=1
XMM26 net69 A1 vdd vdd pmos_hvt w=0.031u l=0.014u m=1
XMM37 net117 C vss vss nmos_hvt w=0.031u l=0.014u m=1
XMM29 net91 B net117 vss nmos_hvt w=0.031u l=0.014u m=1
XMM34 Y net110 vss vss nmos_hvt w=0.031u l=0.014u m=1
XMM31 net110 A1 net91 vss nmos_hvt w=0.031u l=0.014u m=1
XMM30 net110 A2 net91 vss nmos_hvt w=0.031u l=0.014u m=1
.ends gt2_6t_oa211_x1_w31_hvt

.subckt gt2_6t_oa21_x1_w31_hvt A1 A2 B Y vdd vss
*.PININFO A1:I A2:I B:I Y:O vdd:B vss:B
XMM33 Y net98 vdd vdd pmos_hvt w=0.031u l=0.014u m=1
XMM27 net98 A1 net69 vdd pmos_hvt w=0.031u l=0.014u m=1
XMM28 net98 B vdd vdd pmos_hvt w=0.031u l=0.014u m=1
XMM26 net69 A2 vdd vdd pmos_hvt w=0.031u l=0.014u m=1
XMM29 net91 B vss vss nmos_hvt w=0.031u l=0.014u m=1
XMM34 Y net98 vss vss nmos_hvt w=0.031u l=0.014u m=1
XMM31 net98 A2 net91 vss nmos_hvt w=0.031u l=0.014u m=1
XMM30 net98 A1 net91 vss nmos_hvt w=0.031u l=0.014u m=1
.ends gt2_6t_oa21_x1_w31_hvt

.subckt gt2_6t_oa22_x1_w31_hvt A1 A2 B1 B2 Y vdd vss
*.PININFO A1:I A2:I B1:I B2:I Y:O vdd:B vss:B
XMM33 Y net100 vdd vdd pmos_hvt w=0.031u l=0.014u m=1
XMM35 net100 B2 net101 vdd pmos_hvt w=0.031u l=0.014u m=1
XMM27 net100 A2 net69 vdd pmos_hvt w=0.031u l=0.014u m=1
XMM28 net101 B1 vdd vdd pmos_hvt w=0.031u l=0.014u m=1
XMM26 net69 A1 vdd vdd pmos_hvt w=0.031u l=0.014u m=1
XMM29 net91 B1 vss vss nmos_hvt w=0.031u l=0.014u m=1
XMM37 net91 B2 vss vss nmos_hvt w=0.031u l=0.014u m=1
XMM34 Y net100 vss vss nmos_hvt w=0.031u l=0.014u m=1
XMM31 net100 A1 net91 vss nmos_hvt w=0.031u l=0.014u m=1
XMM30 net100 A2 net91 vss nmos_hvt w=0.031u l=0.014u m=1
.ends gt2_6t_oa22_x1_w31_hvt

.subckt gt2_6t_oa31_x1_w31_hvt A1 A2 A3 B Y vdd vss
*.PININFO A1:I A2:I A3:I B:I Y:O vdd:B vss:B
XMM35 net116 A3 net115 vdd pmos_hvt w=0.031u l=0.014u m=1
XMM27 net115 A2 net69 vdd pmos_hvt w=0.031u l=0.014u m=1
XMM33 Y net116 vdd vdd pmos_hvt w=0.031u l=0.014u m=1
XMM28 net116 B vdd vdd pmos_hvt w=0.031u l=0.014u m=1
XMM26 net69 A1 vdd vdd pmos_hvt w=0.031u l=0.014u m=1
XMM29 net91 B vss vss nmos_hvt w=0.031u l=0.014u m=1
XMM34 Y net116 vss vss nmos_hvt w=0.031u l=0.014u m=1
XMM37 net116 A3 net91 vss nmos_hvt w=0.031u l=0.014u m=1
XMM31 net116 A1 net91 vss nmos_hvt w=0.031u l=0.014u m=1
XMM30 net116 A2 net91 vss nmos_hvt w=0.031u l=0.014u m=1
.ends gt2_6t_oa31_x1_w31_hvt

.subckt gt2_6t_oa32_x1_w31_hvt A1 A2 A3 B1 B2 Y vdd vss
*.PININFO A1:I A2:I A3:I B1:I B2:I Y:O vdd:B vss:B
XMM35 net121 A3 net115 vdd pmos_hvt w=0.031u l=0.014u m=1
XMM27 net115 A2 net69 vdd pmos_hvt w=0.031u l=0.014u m=1
XMM40 net121 B2 net122 vdd pmos_hvt w=0.031u l=0.014u m=1
XMM33 Y net121 vdd vdd pmos_hvt w=0.031u l=0.014u m=1
XMM28 net122 B1 vdd vdd pmos_hvt w=0.031u l=0.014u m=1
XMM26 net69 A1 vdd vdd pmos_hvt w=0.031u l=0.014u m=1
XMM38 net91 B2 vss vss nmos_hvt w=0.031u l=0.014u m=1
XMM29 net91 B1 vss vss nmos_hvt w=0.031u l=0.014u m=1
XMM34 Y net121 vss vss nmos_hvt w=0.031u l=0.014u m=1
XMM37 net121 A3 net91 vss nmos_hvt w=0.031u l=0.014u m=1
XMM31 net121 A1 net91 vss nmos_hvt w=0.031u l=0.014u m=1
XMM30 net121 A2 net91 vss nmos_hvt w=0.031u l=0.014u m=1
.ends gt2_6t_oa32_x1_w31_hvt

.subckt gt2_6t_oa33_x1_w31_hvt A1 A2 A3 B1 B2 B3 Y vdd vss
*.PININFO A1:I A2:I A3:I B1:I B2:I B3:I Y:O vdd:B vss:B
XMM33 Y net132 vdd vdd pmos_hvt w=0.031u l=0.014u m=1
XMM40 net133 B2 net122 vdd pmos_hvt w=0.031u l=0.014u m=1
XMM42 net132 B3 net133 vdd pmos_hvt w=0.031u l=0.014u m=1
XMM35 net132 A3 net115 vdd pmos_hvt w=0.031u l=0.014u m=1
XMM27 net115 A2 net69 vdd pmos_hvt w=0.031u l=0.014u m=1
XMM28 net122 B1 vdd vdd pmos_hvt w=0.031u l=0.014u m=1
XMM26 net69 A1 vdd vdd pmos_hvt w=0.031u l=0.014u m=1
XMM38 net91 B3 vss vss nmos_hvt w=0.031u l=0.014u m=1
XMM41 net91 B2 vss vss nmos_hvt w=0.031u l=0.014u m=1
XMM29 net91 B1 vss vss nmos_hvt w=0.031u l=0.014u m=1
XMM34 Y net132 vss vss nmos_hvt w=0.031u l=0.014u m=1
XMM37 net132 A3 net91 vss nmos_hvt w=0.031u l=0.014u m=1
XMM31 net132 A1 net91 vss nmos_hvt w=0.031u l=0.014u m=1
XMM30 net132 A2 net91 vss nmos_hvt w=0.031u l=0.014u m=1
.ends gt2_6t_oa33_x1_w31_hvt

.subckt gt2_6t_oai211_x1_w31_hvt A1 A2 B C Y vdd vss
*.PININFO A1:I A2:I B:I C:I Y:O vdd:B vss:B
XMM27 Y A2 net69 vdd pmos_hvt w=0.031u l=0.014u m=1
XMM35 Y C vdd vdd pmos_hvt w=0.031u l=0.014u m=1
XMM28 Y B vdd vdd pmos_hvt w=0.031u l=0.014u m=1
XMM26 net69 A1 vdd vdd pmos_hvt w=0.031u l=0.014u m=1
XMM37 net117 C vss vss nmos_hvt w=0.031u l=0.014u m=1
XMM29 net91 B net117 vss nmos_hvt w=0.031u l=0.014u m=1
XMM31 Y A1 net91 vss nmos_hvt w=0.031u l=0.014u m=1
XMM30 Y A2 net91 vss nmos_hvt w=0.031u l=0.014u m=1
.ends gt2_6t_oai211_x1_w31_hvt

.subckt gt2_6t_oai21_x1_w31_hvt A1 A2 B Y vdd vss
*.PININFO A1:I A2:I B:I Y:O vdd:B vss:B
XMM27 Y A1 net69 vdd pmos_hvt w=0.031u l=0.014u m=1
XMM28 Y B vdd vdd pmos_hvt w=0.031u l=0.014u m=1
XMM26 net69 A2 vdd vdd pmos_hvt w=0.031u l=0.014u m=1
XMM29 net91 B vss vss nmos_hvt w=0.031u l=0.014u m=1
XMM31 Y A2 net91 vss nmos_hvt w=0.031u l=0.014u m=1
XMM30 Y A1 net91 vss nmos_hvt w=0.031u l=0.014u m=1
.ends gt2_6t_oai21_x1_w31_hvt

.subckt gt2_6t_oai22_x1_w31_hvt A1 A2 B1 B2 Y vdd vss
*.PININFO A1:I A2:I B1:I B2:I Y:O vdd:B vss:B
XMM35 Y B2 net101 vdd pmos_hvt w=0.031u l=0.014u m=1
XMM27 Y A2 net69 vdd pmos_hvt w=0.031u l=0.014u m=1
XMM28 net101 B1 vdd vdd pmos_hvt w=0.031u l=0.014u m=1
XMM26 net69 A1 vdd vdd pmos_hvt w=0.031u l=0.014u m=1
XMM37 net91 B2 vss vss nmos_hvt w=0.031u l=0.014u m=1
XMM29 net91 B1 vss vss nmos_hvt w=0.031u l=0.014u m=1
XMM31 Y A1 net91 vss nmos_hvt w=0.031u l=0.014u m=1
XMM30 Y A2 net91 vss nmos_hvt w=0.031u l=0.014u m=1
.ends gt2_6t_oai22_x1_w31_hvt

.subckt gt2_6t_oai31_x1_w31_hvt A1 A2 A3 B Y vdd vss
*.PININFO A1:I A2:I A3:I B:I Y:O vdd:B vss:B
XMM35 Y A3 net115 vdd pmos_hvt w=0.031u l=0.014u m=1
XMM28 Y B vdd vdd pmos_hvt w=0.031u l=0.014u m=1
XMM27 net115 A2 net69 vdd pmos_hvt w=0.031u l=0.014u m=1
XMM26 net69 A1 vdd vdd pmos_hvt w=0.031u l=0.014u m=1
XMM29 net91 B vss vss nmos_hvt w=0.031u l=0.014u m=1
XMM37 Y A3 net91 vss nmos_hvt w=0.031u l=0.014u m=1
XMM31 Y A1 net91 vss nmos_hvt w=0.031u l=0.014u m=1
XMM30 Y A2 net91 vss nmos_hvt w=0.031u l=0.014u m=1
.ends gt2_6t_oai31_x1_w31_hvt

.subckt gt2_6t_oai32_x1_w31_hvt A1 A2 A3 B1 B2 Y vdd vss
*.PININFO A1:I A2:I A3:I B1:I B2:I Y:O vdd:B vss:B
XMM40 Y B2 net122 vdd pmos_hvt w=0.031u l=0.014u m=1
XMM35 Y A3 net115 vdd pmos_hvt w=0.031u l=0.014u m=1
XMM27 net115 A2 net69 vdd pmos_hvt w=0.031u l=0.014u m=1
XMM28 net122 B1 vdd vdd pmos_hvt w=0.031u l=0.014u m=1
XMM26 net69 A1 vdd vdd pmos_hvt w=0.031u l=0.014u m=1
XMM29 net91 B1 vss vss nmos_hvt w=0.031u l=0.014u m=1
XMM38 net91 B2 vss vss nmos_hvt w=0.031u l=0.014u m=1
XMM37 Y A3 net91 vss nmos_hvt w=0.031u l=0.014u m=1
XMM31 Y A1 net91 vss nmos_hvt w=0.031u l=0.014u m=1
XMM30 Y A2 net91 vss nmos_hvt w=0.031u l=0.014u m=1
.ends gt2_6t_oai32_x1_w31_hvt

.subckt gt2_6t_oai33_x1_w31_hvt A1 A2 A3 B1 B2 B3 Y vdd vss
*.PININFO A1:I A2:I A3:I B1:I B2:I B3:I Y:O vdd:B vss:B
XMM42 Y B3 net133 vdd pmos_hvt w=0.031u l=0.014u m=1
XMM35 Y A3 net115 vdd pmos_hvt w=0.031u l=0.014u m=1
XMM40 net133 B2 net122 vdd pmos_hvt w=0.031u l=0.014u m=1
XMM27 net115 A2 net69 vdd pmos_hvt w=0.031u l=0.014u m=1
XMM28 net122 B1 vdd vdd pmos_hvt w=0.031u l=0.014u m=1
XMM26 net69 A1 vdd vdd pmos_hvt w=0.031u l=0.014u m=1
XMM38 net91 B3 vss vss nmos_hvt w=0.031u l=0.014u m=1
XMM41 net91 B2 vss vss nmos_hvt w=0.031u l=0.014u m=1
XMM29 net91 B1 vss vss nmos_hvt w=0.031u l=0.014u m=1
XMM37 Y A3 net91 vss nmos_hvt w=0.031u l=0.014u m=1
XMM31 Y A1 net91 vss nmos_hvt w=0.031u l=0.014u m=1
XMM30 Y A2 net91 vss nmos_hvt w=0.031u l=0.014u m=1
.ends gt2_6t_oai33_x1_w31_hvt

.subckt gt2_6t_or2_x1_w31_hvt A B Y vdd vss
*.PININFO A:I B:I Y:O vdd:B vss:B
XMM8 Y net27 vss vss nmos_hvt w=0.031u l=0.014u m=1
XMM3 net27 B vss vss nmos_hvt w=0.031u l=0.014u m=1
XMM1 net27 A vss vss nmos_hvt w=0.031u l=0.014u m=1
XMM7 Y net27 vdd vdd pmos_hvt w=0.031u l=0.014u m=1
XMM2 net27 A net31 vdd pmos_hvt w=0.031u l=0.014u m=1
XMM0 net31 B vdd vdd pmos_hvt w=0.031u l=0.014u m=1
.ends gt2_6t_or2_x1_w31_hvt

.subckt gt2_6t_or2_x2_w31_hvt A B Y vdd vss
*.PININFO A:I B:I Y:O vdd:B vss:B
XMM8 Y net27 vss vss nmos_hvt w=0.031u l=0.014u m=2
XMM3 net27 B vss vss nmos_hvt w=0.031u l=0.014u m=1
XMM1 net27 A vss vss nmos_hvt w=0.031u l=0.014u m=1
XMM7 Y net27 vdd vdd pmos_hvt w=0.031u l=0.014u m=2
XMM2 net27 A net31 vdd pmos_hvt w=0.031u l=0.014u m=1
XMM0 net31 B vdd vdd pmos_hvt w=0.031u l=0.014u m=1
.ends gt2_6t_or2_x2_w31_hvt

.subckt gt2_6t_or2_x3_w31_hvt A B Y vdd vss
*.PININFO A:I B:I Y:O vdd:B vss:B
XMM8 Y net27 vss vss nmos_hvt w=0.031u l=0.014u m=3
XMM3 net27 B vss vss nmos_hvt w=0.031u l=0.014u m=1
XMM1 net27 A vss vss nmos_hvt w=0.031u l=0.014u m=1
XMM7 Y net27 vdd vdd pmos_hvt w=0.031u l=0.014u m=3
XMM2 net27 A net31 vdd pmos_hvt w=0.031u l=0.014u m=1
XMM0 net31 B vdd vdd pmos_hvt w=0.031u l=0.014u m=1
.ends gt2_6t_or2_x3_w31_hvt

.subckt gt2_6t_or2_x4_w31_hvt A B Y vdd vss
*.PININFO A:I B:I Y:O vdd:B vss:B
XMM8 Y net27 vss vss nmos_hvt w=0.031u l=0.014u m=4
XMM3 net27 B vss vss nmos_hvt w=0.031u l=0.014u m=1
XMM1 net27 A vss vss nmos_hvt w=0.031u l=0.014u m=1
XMM7 Y net27 vdd vdd pmos_hvt w=0.031u l=0.014u m=4
XMM2 net27 A net31 vdd pmos_hvt w=0.031u l=0.014u m=1
XMM0 net31 B vdd vdd pmos_hvt w=0.031u l=0.014u m=1
.ends gt2_6t_or2_x4_w31_hvt

.subckt gt2_6t_or3_x1_w31_hvt A B C Y vdd vss
*.PININFO A:I B:I C:I Y:O vdd:B vss:B
XMM8 Y net36 vss vss nmos_hvt w=0.031u l=0.014u m=1
XMM10 net36 C vss vss nmos_hvt w=0.031u l=0.014u m=1
XMM3 net36 B vss vss nmos_hvt w=0.031u l=0.014u m=1
XMM1 net36 A vss vss nmos_hvt w=0.031u l=0.014u m=1
XMM7 Y net36 vdd vdd pmos_hvt w=0.031u l=0.014u m=1
XMM9 net36 C net37 vdd pmos_hvt w=0.031u l=0.014u m=1
XMM2 net37 B net31 vdd pmos_hvt w=0.031u l=0.014u m=1
XMM0 net31 A vdd vdd pmos_hvt w=0.031u l=0.014u m=1
.ends gt2_6t_or3_x1_w31_hvt

.subckt gt2_6t_tiehigh_w31_hvt Y vdd vss
*.PININFO Y:O vdd:B vss:B
XMM1 net8 net8 vss vss nmos_hvt w=0.031u l=0.014u m=1
XMM0 Y net8 vdd vdd pmos_hvt w=0.031u l=0.014u m=1
.ends gt2_6t_tiehigh_w31_hvt

.subckt gt2_6t_tielow_w31_hvt Y vdd vss
*.PININFO Y:O vdd:B vss:B
XMM1 Y net9 vss vss nmos_hvt w=0.031u l=0.014u m=1
XMM0 net9 net9 vdd vdd pmos_hvt w=0.031u l=0.014u m=1
.ends gt2_6t_tielow_w31_hvt

.subckt gt2_6t_xnor2_x1_w31_hvt A B Y vdd vss
*.PININFO A:I B:I Y:O vdd:B vss:B
XMM27 Y A net69 vdd pmos_hvt w=0.031u l=0.014u m=1
XMM28 Y net84 vdd vdd pmos_hvt w=0.031u l=0.014u m=1
XMM26 net69 B vdd vdd pmos_hvt w=0.031u l=0.014u m=1
XMM25 net84 A vdd vdd pmos_hvt w=0.031u l=0.014u m=1
XMM22 net84 B vdd vdd pmos_hvt w=0.031u l=0.014u m=1
XMM31 net81 B vss vss nmos_hvt w=0.031u l=0.014u m=1
XMM30 net81 A vss vss nmos_hvt w=0.031u l=0.014u m=1
XMM29 Y net84 net81 vss nmos_hvt w=0.031u l=0.014u m=1
XMM24 net60 B vss vss nmos_hvt w=0.031u l=0.014u m=1
XMM23 net84 A net60 vss nmos_hvt w=0.031u l=0.014u m=1
.ends gt2_6t_xnor2_x1_w31_hvt

.subckt gt2_6t_xor2_x1_w31_hvt A B Y vdd vss
*.PININFO A:I B:I Y:O vdd:B vss:B
XMM18 net41 B vss vss nmos_hvt w=0.031u l=0.014u m=1
XMM19 Y net24 vss vss nmos_hvt w=0.031u l=0.014u m=1
XMM17 Y A net41 vss nmos_hvt w=0.031u l=0.014u m=1
XMM13 net24 A vss vss nmos_hvt w=0.031u l=0.014u m=1
XMM11 net24 B vss vss nmos_hvt w=0.031u l=0.014u m=1
XMM16 Y net24 net33 vdd pmos_hvt w=0.031u l=0.014u m=1
XMM12 net24 A net23 vdd pmos_hvt w=0.031u l=0.014u m=1
XMM15 net33 A vdd vdd pmos_hvt w=0.031u l=0.014u m=1
XMM14 net33 B vdd vdd pmos_hvt w=0.031u l=0.014u m=1
XMM10 net23 B vdd vdd pmos_hvt w=0.031u l=0.014u m=1
.ends gt2_6t_xor2_x1_w31_hvt

.subckt gt2_6t_filler_w31_hvt vdd vss
.ends gt2_6t_filler_w31_hvt

.subckt gt2_6t_tapfspdn_w31_hvt vdd vss
.ends gt2_6t_tapfspdn_w31_hvt

.subckt gt2_6t_tapbspdn_w31_hvt vdd vss
.ends gt2_6t_tapbspdn_w31_hvt
